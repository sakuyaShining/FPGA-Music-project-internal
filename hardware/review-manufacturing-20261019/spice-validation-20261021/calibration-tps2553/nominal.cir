TPS2553 vendor-model nominal startup smoke check
.include "C:/Users/Sakuya/.codex/worktrees/06df/FPGA-Music-project/hardware/review-manufacturing-20261019/spice-validation-20261021/vendor-TI-TPS2553/SLVM425A/TPS2553_PSPICE_TRANS/tps2553_trans.lib"
Vsrc vin 0 5
Ven en 0 PWL(0 0 1m 0 1.001m 3.3 20m 3.3)
Vpull pull 0 3.3
Xswitch vin 0 en 0 fault ilim out TPS2553_TRANS
Rilim ilim 0 23.7k
Rfault pull fault 100k
Cin vin 0 2.2u
Cout out 0 2.2u
Rload out 0 6.25
.save v(vin) v(en) v(out) v(fault) i(Vsrc)
.control
set wr_singlescale
set wr_vecnames
tran 2u 20m
wrdata waveform.txt v(vin) v(en) v(out) v(fault) i(Vsrc)
quit
.endc
.end
