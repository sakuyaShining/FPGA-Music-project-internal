TPS2553 local application scenario, vendor model with audited syntax adapter
.include "C:/Users/Sakuya/.codex/worktrees/06df/FPGA-Music-project/hardware/review-manufacturing-20261019/spice-validation-20261021/tps2553_ngspice41_compat.lib"
Vadapter adapter 0 PWL(0 0 1m 0 1.01m 5.0 0.1 5.0)
Splug adapter connected plugctl 0 PLUG
.model PLUG SW(Ron=.001 Roff=1e12 Vt=.5 Vh=0)
Vplugctl plugctl 0 PWL(0 1 60m 1 60.01m 0 100m 0)
Rup connected vin 0.35
Cin vin 0 2.2u
Vsense vin switch_in 0
Ven en 0 PWL(0 0 3m 0 3.01m 3.3 0.1 3.3)
Xswitch switch_in 0 en 0 fault ilim out TPS2553_TRANS
Rilim ilim 0 23700
* Idealized powered pullup only; not an AP2112 regulator model.
Bpull pull 0 V={min(max(V(out),0),3.3)}
Rfault pull fault 100k
Rbleed out 0 10k
Resr out cap .05
Ctotal cap 0 0.0001044
Bload out 0 I={0.2*tanh(V(out)/.05)}
.save v(adapter) v(vin) v(en) v(out) v(fault) i(Vadapter) i(Vsense)
.control
set wr_singlescale
set wr_vecnames
tran 5e-06 0.1
wrdata waveform.txt v(adapter) v(vin) v(en) v(out) v(fault) i(Vadapter) i(Vsense)
quit
.endc
.end
